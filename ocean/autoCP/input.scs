parameters vinp=0.15
// Design: newUMC18/cp8s
simulator lang=spectre
global 0
parameters //vinp=0.3
include "/research/KAN/UM18/oa/UMC_18_CMOS/../Models/Spectre/mm180_bjt_v121.lib.scs" section=tt_bip
include "/research/KAN/UM18/oa/UMC_18_CMOS/../Models/Spectre/mm180_mimcap_v101.lib.scs" section=mimcaps_typ
include "/research/KAN/UM18/oa/UMC_18_CMOS/../Models/Spectre/mm180_reg18bpw_v123.lib.scs" section=tt
include "/research/KAN/UM18/oa/UMC_18_CMOS/../Models/Spectre/mm180_reg33bpw_v123.lib.scs" section=tt
include "/research/KAN/UM18/oa/UMC_18_CMOS/../Models/Spectre/mm180_res_v141.lib.scs" section=res_typ
include "/research/KAN/UM18/oa/UMC_18_CMOS/../Models/Spectre/mm180_lvt18_v113.lib.scs" section=tt
include "/research/KAN/UM18/oa/UMC_18_CMOS/../Models/Spectre/mm180_lvt33_v113.lib.scs" section=tt
include "/research/KAN/UM18/oa/UMC_18_CMOS/../Models/Spectre/mm180_reg18_v124.lib.scs" section=tt
include "/research/KAN/UM18/oa/UMC_18_CMOS/../Models/Spectre/mm180_reg33_v114.lib.scs" section=tt
include "/research/KAN/UM18/oa/UMC_18_CMOS/../Models/Spectre/mm180_zvt18_v121.lib.scs" section=tt
include "/research/KAN/UM18/oa/UMC_18_CMOS/../Models/Spectre/mm180_zvt33_v113.lib.scs" section=tt
include "/research/KAN/UM18/oa/UMC_18_CMOS/../Models/Spectre/core_rf_v2d4.lib.scs" section=tt
include "/research/KAN/UM18/oa/UMC_18_CMOS/../Models/Spectre/io_rf_v2d3.lib.scs" section=tt
include "/research/KAN/UM18/oa/UMC_18_CMOS/../Models/Spectre/l_slcr20k_rf_v2d3.lib.scs" section=typ
include "/research/KAN/UM18/oa/UMC_18_CMOS/../Models/Spectre/mimcapm_rf_v2d3.lib.scs" section=typ
include "/research/KAN/UM18/oa/UMC_18_CMOS/../Models/Spectre/pad_rf_v2d3.lib.scs" section=typ
include "/research/KAN/UM18/oa/UMC_18_CMOS/../Models/Spectre/rnhr_rf_v2d4.lib.scs" section=typ
include "/research/KAN/UM18/oa/UMC_18_CMOS/../Models/Spectre/rnnpo_rf_v2d4.lib.scs" section=typ
include "/research/KAN/UM18/oa/UMC_18_CMOS/../Models/Spectre/rnppo_rf_v2d4.lib.scs" section=typ
include "/research/KAN/UM18/oa/UMC_18_CMOS/../Models/Spectre/vardiop_rf_v2d3.lib.scs" section=typ
include "/research/KAN/UM18/oa/UMC_18_CMOS/../Models/Spectre/varmis_18_rf_v2d3.lib.scs" section=typ
include "/research/KAN/UM18/oa/UMC_18_CMOS/../Models/Spectre/mm180_diode_v113.mdl.scs"

// myUMC18/Cdiode/schematic
subckt Cdiode VD VF VLG VS VSG
    M2 (VSG VF VSG VSG) p_18_mm w=8.8u l=4.4u nf=1 mis_flag=1 m=(1)*(1) mf=(1)*(1)
    M1 (VLG VF VLG VLG) p_18_mm w=20u l=25.0u nf=1 mis_flag=1 m=(1)*(1) mf=(1)*(1)
    M0 (VD VF VD VD) p_18_mm w=12.5u l=8u nf=1 mis_flag=1 m=(1)*(1) mf=(1)*(1)
    M14 (VD VF VS VD) n_bpw_18_mm w=3u l=360.0n m=(3)*(1)
ends Cdiode

// myUMC18/CP_1s_cdiode/schematic
subckt CP_1s_cdiode VF0 VF1 VGND VIN\+ VIN\- VLG\<0\> VLG\<1\> VM VOUT VSG\<0\> VSG\<1\>
    C0 (VGND VOUT) mimcaps_mm w=45.0u l=45.0u m=1
    C1 (VIN\+ VM) mimcaps_mm w=45.0u l=45.0u m=1
    I7 (VIN\- VF0 VLG\<0\> VM VSG\<0\>) Cdiode
    I6 (VM VF1 VLG\<1\> VOUT VSG\<1\>) Cdiode
ends CP_1s_cdiode

// myUMC18/CP_2s_cdiode/schematic
subckt CP_2s_cdiode VF0 VF1 VF2 VF3 VGND VIN\+ VIN\- VLG\<0\> VLG\<1\> VLG\<2\> VLG\<3\> VM\<0\> VM\<1\> VM\<2\> VOUT VSG\<0\> VSG\<1\> VSG\<2\> VSG\<3\>
    I1 (VF2 VF3 VGND VIN\+ VM\<1\> VLG\<2\> VLG\<3\> VM\<2\> VOUT VSG\<2\> VSG\<3\>) CP_1s_cdiode
    I0 (VF0 VF1 VGND VIN\+ VIN\- VLG\<0\> VLG\<1\> VM\<0\> VM\<1\> VSG\<0\> VSG\<1\>) CP_1s_cdiode
ends CP_2s_cdiode

// myUMC18/CP_4s_cdiode/schematic
subckt CP_4s_cdiode VF0 VF1 VF2 VF3 VF4 VF5 VF6 VF7 VGND VIN\+ VIN\- VLG\<0\> VLG\<1\> VLG\<2\> VLG\<3\> VLG\<4\> VLG\<5\> VLG\<6\> VLG\<7\> VM\<0\> VM\<1\> VM\<2\> VM\<3\> VM\<4\> VM\<5\> VM\<6\> VOUT VSG\<0\> VSG\<1\> VSG\<2\> VSG\<3\> VSG\<4\> VSG\<5\> VSG\<6\> VSG\<7\>
    I1 (VF4 VF5 VF6 VF7 VGND VIN\+ VM\<3\> VLG\<4\> VLG\<5\> VLG\<6\> VLG\<7\> VM\<4\> VM\<5\> VM\<6\> VOUT VSG\<4\> VSG\<5\> VSG\<6\> VSG\<7\>) CP_2s_cdiode
    I0 (VF0 VF1 VF2 VF3 VGND VIN\+ VIN\- VLG\<0\> VLG\<1\> VLG\<2\> VLG\<3\> VM\<0\> VM\<1\> VM\<2\> VM\<3\> VSG\<0\> VSG\<1\> VSG\<2\> VSG\<3\>) CP_2s_cdiode
ends CP_4s_cdiode

// newUMC18/cp8s/schematic
I1 (VF8 VF9 VF10 VF11 VF12 VF13 VF14 VF15 0 VIN\+ VM\<7\> net19\<0\> net19\<1\> net19\<2\> net19\<3\> net19\<4\> net19\<5\> net19\<6\> net19\<7\> net21\<0\> net21\<1\> net21\<2\> net21\<3\> net21\<4\> net21\<5\> net21\<6\> VOUT net20\<0\> net20\<1\> net20\<2\> net20\<3\> net20\<4\> net20\<5\> net20\<6\> net20\<7\>) CP_4s_cdiode
I0 (VF0 VF1 VF2 VF3 VF4 VF5 VF6 VF7 0 VIN\+ 0 net22\<0\> net22\<1\> net22\<2\> net22\<3\> net22\<4\> net22\<5\> net22\<6\> net22\<7\> net24\<0\> net24\<1\> net24\<2\> net24\<3\> net24\<4\> net24\<5\> net24\<6\> VM\<7\> net23\<0\> net23\<1\> net23\<2\> net23\<3\> net23\<4\> net23\<5\> net23\<6\> net23\<7\>) CP_4s_cdiode
V0 (VIN\+ 0) vsource type=sine ampl=vinp freq=1G
ic VF15=0.4 VF14=0.4 VF13=0.4 VF12=0.4 VF11=0.4 VF10=0.4 VF9=0.4 VF8=0.4 VF7=0.4 VF6=0.4 VF5=0.4 VF4=0.4 VF3=0.4 VF2=0.4 VF1=0.4 VF0=0.4
simulatorOptions options temp=27
//tran tran stop=5000n errpreset=conservative write="spectre.ic" // writefinal="spectre.fc" annotate=status maxiters=5
//finalTimeOP info what=oppoint where=rawfile
//modelParameter info what=models where=rawfile
//element info what=inst where=rawfile
//outputParameter info what=output where=rawfile
//designParamVals info what=parameters where=rawfile
//primitives info what=primitives where=rawfile
//subckts info what=subckts where=rawfile
//save VOUT
//saveOptions options save=allpub
ic VF15=0.4 VF14=0.4 VF13=0.4 VF12=0.4 VF11=0.4 VF10=0.4 VF9=0.4 VF8=0.4 VF7=0.4 VF6=0.4 VF5=0.4 VF4=0.4 VF3=0.4 VF2=0.4 VF1=0.4 VF0=0.4
simulatorOptions options temp=27
tran tran stop=5e-06 errpreset=moderate
save VOUT
